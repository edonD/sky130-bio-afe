* MASH 1-1 Switched-Capacitor Sigma-Delta ADC — Transistor Level
* SKY130 130nm CMOS, 1.8V supply
* fs=1MHz, OSR=64, fin=1.5kHz (EEG/ECG band)
*
* ARCHITECTURE: MASH 1-1 (Multi-stAge noise SHaping, 1st+1st order cascade)
*   Stage 1: 1st-order SC SDM, input=Vin, DAC=vdac1_q (its OWN comparator)
*            → y1 bitstream at /tmp/adc_tran.dat column vdac1_q
*   Stage 2: 1st-order SC SDM, input=Stage1 RESIDUE (vint1_out - vdac1)
*            DAC=vdac2_q (its OWN comparator, independent loop)
*            → y2 bitstream at /tmp/adc_tran.dat column vdac2_q
*   Digital: y_final[n] = y1[n] + (y2[n] - y2[n-1]) → 2nd-order NTF
*            NTF(z) = (1-z⁻¹)²
*
* WHY MASH OVER CIFB:
*   CIFB: comparator on INT2 → INT1 wanders far from VCM before correction → clips
*   MASH: each stage has its own direct feedback loop → INT1 stays bounded like
*         the proven 1st-order design. Stage 2 clipping gets shaped by (1-z⁻¹)
*         in the digital combination → negligible in-band contribution.
*
* Stage 1: a1=Cs1/Ci1=0.125 (reduced → integrator max=1.125V < OTA Vout_max=1.20V, no clipping)
* Stage 2: two input caps:
*   Cs2a samples residue = vint1_out - vdac1 (Stage 1 analog residue)
*   Cs2b = vcmbias top, bot switches between vdac2 (phi1) and vint2_in (phi2)
*          → implements Stage 2 DAC subtraction
*   a2 = Cs2a/Ci2 = Cs2b/Ci2 = 0.5
*
* COHERENCE: fin=1.5kHz, N=10000 bits at fs=1MHz → signal at EXACT bin 15
*            → no spectral leakage in bitstream FFT → accurate SNDR measurement
* ============================================================

.lib sky130_models/sky130.lib.spice tt

* ============================================================
* Parameters
* ============================================================
.param VDD    = 1.8
.param VCM    = 0.9

* Stage 1: a1 = Cs1/Ci1 = 0.175 → integrator max≈1.18V < OTA Vout_max=1.20V (no clipping)
* Max swing: a1*(Vin_max - Vdac_min) = 0.175*1.6 = 0.28V → Vout_max = 1.18V (safe)
* Larger a1 vs 0.125 → less idle tone locking, better shaped noise → better OSR=256 SNDR
.param Cs1    = 0.7e-12  ; 0.7pF sampling cap  (a1=0.175, best SNDR sweet spot)
.param Ci1    = 4e-12    ; 4pF integration cap

* Stage 2: a2 = Cs2/Ci2 = 0.5 (per cap; Stage 2 may clip, that's OK for MASH)
.param Cs2a   = 2e-12    ; 2pF residue signal sampling cap
.param Cs2b   = 2e-12    ; 2pF Stage-2 feedback cap
.param Ci2    = 4e-12    ; 4pF integration cap

* OTA sizing — minimal noise floor (proven 1st-order geometry)
.param p_wn_in   = 4e-6
.param p_ln_in   = 0.5e-6
.param p_wp_load = 4e-6
.param p_lp_load = 1e-6
.param p_wn_tail = 4e-6
.param p_ln_tail = 2e-6
.param p_wp_2nd  = 16e-6
.param p_lp_2nd  = 0.5e-6
.param p_wn_2nd  = 8e-6
.param p_ln_2nd  = 0.5e-6
.param p_cc      = 4e-12
.param p_ibias   = 50e-6

* ============================================================
* Power supplies
* ============================================================
VDD  vdd  0  DC 1.8
VVSS vss  0  DC 0

* ============================================================
* Input: Vin = 0.9V + 0.7V*sin(2pi*1.5kHz*t)
* ============================================================
Vin_src  vin_src  0  DC 0.9  SIN(0.9 0.7 1.5e3 0 0)
Rvin     vin_src  vin  100

* ============================================================
* Non-overlapping clocks (Ts=1µs)
* phi1 HIGH: 0–490ns   phi2 HIGH: 510–1000ns   dead=20ns
* ============================================================
Vphi1  phi1_src  0  PULSE(0   1.8  0     2n 2n  486n  1u)
Vphi1b phi1b_src 0  PULSE(1.8 0    0     2n 2n  486n  1u)
Vphi2  phi2_src  0  PULSE(0   1.8  510n  2n 2n  486n  1u)
Vphi2b phi2b_src 0  PULSE(1.8 0    510n  2n 2n  486n  1u)
Rphi1  phi1_src  phi1  100
Rphi1b phi1b_src phi1b 100
Rphi2  phi2_src  phi2  100
Rphi2b phi2b_src phi2b 100

* ============================================================
* Bias (shared vbn for both OTA instances)
* Stage 1 uses vcmbias.  Stage 2 uses vcmbias2 (ISOLATED to prevent crosstalk:
*   Cs2b top-plate switching would perturb vcmbias and corrupt OTA1's non-inv input)
* ============================================================
Vcmbias  vcmbias_src  0 DC 0.9
Rcmbias  vcmbias_src  vcmbias  100
Vcmbias2 vcmbias2_src 0 DC 0.9
Rcmbias2 vcmbias2_src vcmbias2 100
Ibias  vdd  vbn  DC {p_ibias}
XMbias vbn  vbn  vss vss  sky130_fd_pr__nfet_01v8  w={p_wn_tail} l={p_ln_tail} m=1

* ============================================================
* OTA — Two-stage Miller-compensated
* Ports: vip  vin  vout  vdd  vss  vbn
* vip = INVERTING input (M1 gate: vip↑→vout↓) → use at virtual-ground node
* ============================================================
.subckt ota  vip  vin  vout  vdd  vss  vbn
XMtail  ntail  vbn    vss  vss  sky130_fd_pr__nfet_01v8  w={p_wn_tail} l={p_ln_tail} m=1
XM1     nd1    vip    ntail vss  sky130_fd_pr__nfet_01v8  w={p_wn_in}   l={p_ln_in}   m=2
XM2     nd2    vin    ntail vss  sky130_fd_pr__nfet_01v8  w={p_wn_in}   l={p_ln_in}   m=2
XM3     nd1    nd1    vdd   vdd  sky130_fd_pr__pfet_01v8  w={p_wp_load} l={p_lp_load} m=1
XM4     nd2    nd1    vdd   vdd  sky130_fd_pr__pfet_01v8  w={p_wp_load} l={p_lp_load} m=1
XM5     vout   nd2    vdd   vdd  sky130_fd_pr__pfet_01v8  w={p_wp_2nd}  l={p_lp_2nd}  m=2
XM6     vout   vbn    vss   vss  sky130_fd_pr__nfet_01v8  w={p_wn_2nd}  l={p_ln_2nd}  m=1
Cc      nd2    cc_int {p_cc}
Rz      cc_int vout   2200
.ends ota

* ============================================================
* Transmission Gate — closed when ph=HIGH
* ============================================================
.subckt tg  in  out  ph  phb  vdd  vss
XMN  in  ph   out  vss  sky130_fd_pr__nfet_01v8  w=1e-6  l=150n  m=1
XMP  in  phb  out  vdd  sky130_fd_pr__pfet_01v8  w=2e-6  l=150n  m=1
.ends tg

* ============================================================
* STAGE 1: 1st-order SC Integrator + Comparator + S&H
* Δx1 = +(Cs1/Ci1)*(Vin - vdac1) = +0.75*(Vin - vdac1)
* Comparator fires on vint1_out, drives vdac1_q (Stage 1's OWN bitstream)
* ============================================================

* SC Integrator 1
Xs1a  vin       cs1_top  phi1  phi1b  vdd  vss  tg
Xs1b  vdac1     cs1_bot  phi1  phi1b  vdd  vss  tg
Xs2a  vcmbias   cs1_top  phi2  phi2b  vdd  vss  tg
Xs2b  vint1_in  cs1_bot  phi2  phi2b  vdd  vss  tg
Cs1_cap  cs1_top  cs1_bot  {Cs1}
Xota1    vint1_in  vcmbias  vint1_out  vdd  vss  vbn  ota
Ci1_int  vint1_out  vint1_in  {Ci1}

* Comparator 1: 4-inverter chain (NON-INVERTING total: even inversions) on vint1_out
* vint1_out > VCM → comp1a=LOW → comp1b=HIGH → comp1c=LOW → comp1d=HIGH → vdac1=1.8V
* Four stages give Av≈(-20)^4: rail-to-rail output even for ~0.1mV overdrive at VCM
* → Δx1=+(Cs1/Ci1)*(Vin-1.8)<0 → NEGATIVE FEEDBACK ✓
XMnA  comp1a_out  vint1_out    vss  vss  sky130_fd_pr__nfet_01v8  w=4e-6  l=150n  m=1
XMpA  comp1a_out  vint1_out    vdd  vdd  sky130_fd_pr__pfet_01v8  w=12e-6 l=150n  m=1
XMnB  comp1b_out  comp1a_out   vss  vss  sky130_fd_pr__nfet_01v8  w=4e-6  l=150n  m=1
XMpB  comp1b_out  comp1a_out   vdd  vdd  sky130_fd_pr__pfet_01v8  w=12e-6 l=150n  m=1
XMnC1 comp1c_out  comp1b_out   vss  vss  sky130_fd_pr__nfet_01v8  w=4e-6  l=150n  m=1
XMpC1 comp1c_out  comp1b_out   vdd  vdd  sky130_fd_pr__pfet_01v8  w=12e-6 l=150n  m=1
XMnD1 comp1d_out  comp1c_out   vss  vss  sky130_fd_pr__nfet_01v8  w=4e-6  l=150n  m=1
XMpD1 comp1d_out  comp1c_out   vdd  vdd  sky130_fd_pr__pfet_01v8  w=12e-6 l=150n  m=1

* S&H 1: transparent during phi1 → samples comp1d_out → vdac1_q (holds during phi2)
Xtg_sh1  comp1d_out  vdac1_q  phi1  phi1b  vdd  vss  tg
Ch_dac1  vdac1_q  vss  10e-12
Rdac1    vdac1_q  vdac1  1

* ============================================================
* STAGE 2: 1st-order SC SDM on Stage 1 residue
*
* Input: residue1 = vint1_out - vdac1  (Stage 1 analog residue, sampled on Cs2a)
* DAC:   vdac2_q                        (Stage 2's OWN DAC, subtracted via Cs2b)
*
* Two-cap structure:
*   Cs2a: phi1: top=vint1_out, bot=vdac1   → ΔQ_a = Cs2a*(vint1_out - vdac1)
*         phi2: top=VCM, bot=vint2_in       → transfer residue to OTA2
*   Cs2b: top permanently tied to vcmbias (VCM=0.9V)
*         phi1: bot=vdac2   → Q_b = Cs2b*(VCM - vdac2)  [DAC feedback]
*         phi2: bot=vint2_in → Q_b = 0                   [transfer]
*         ΔQ_b = Cs2b*(VCM - vdac2) = -Cs2b*(vdac2 - VCM)  [subtracts DAC2]
*
* Δx2 = [Cs2a*(vint1_out-vdac1) + Cs2b*(VCM-vdac2)] / Ci2
*      = 0.5*[(vint1_out-vdac1) - (vdac2-VCM)]
* ============================================================

* 100Ω buffer on vint1_out → vint1_s2 prevents Stage2 caps from hard-loading OTA1 output
Rbuf_s2  vint1_out  vint1_s2  100

* Cs2a: residue signal sampling (uses isolated vcmbias2 for top-plate reset)
Xs3a  vint1_s2   cs2a_top  phi1  phi1b  vdd  vss  tg
Xs3b  vdac1      cs2a_bot  phi1  phi1b  vdd  vss  tg
Xs4a  vcmbias2   cs2a_top  phi2  phi2b  vdd  vss  tg
Xs4b  vint2_in   cs2a_bot  phi2  phi2b  vdd  vss  tg
Cs2a_cap  cs2a_top  cs2a_bot  {Cs2a}

* Cs2b: Stage 2 DAC feedback (top permanently at vcmbias2 — ISOLATED from Stage 1's vcmbias)
* Switching cs2b_bot no longer couples into Stage 1's vcmbias reference
Xs5b  vdac2     cs2b_bot  phi1  phi1b  vdd  vss  tg
Xs6b  vint2_in  cs2b_bot  phi2  phi2b  vdd  vss  tg
Cs2b_cap  vcmbias2  cs2b_bot  {Cs2b}

* OTA2 and integration cap (uses vcmbias2 as its fixed reference)
Xota2    vint2_in  vcmbias2  vint2_out  vdd  vss  vbn  ota
Ci2_int  vint2_out  vint2_in  {Ci2}

* Comparator 2: 4-inverter chain on vint2_out (Stage 2's own comparator)
* vint2_out > VCM → comp2a=LOW → comp2b=HIGH → comp2c=LOW → comp2d=HIGH → vdac2=1.8V
XMnC  comp2a_out  vint2_out    vss  vss  sky130_fd_pr__nfet_01v8  w=4e-6  l=150n  m=1
XMpC  comp2a_out  vint2_out    vdd  vdd  sky130_fd_pr__pfet_01v8  w=12e-6 l=150n  m=1
XMnD  comp2b_out  comp2a_out   vss  vss  sky130_fd_pr__nfet_01v8  w=4e-6  l=150n  m=1
XMpD  comp2b_out  comp2a_out   vdd  vdd  sky130_fd_pr__pfet_01v8  w=12e-6 l=150n  m=1
XMnE  comp2c_out  comp2b_out   vss  vss  sky130_fd_pr__nfet_01v8  w=4e-6  l=150n  m=1
XMpE  comp2c_out  comp2b_out   vdd  vdd  sky130_fd_pr__pfet_01v8  w=12e-6 l=150n  m=1
XMnF  comp2d_out  comp2c_out   vss  vss  sky130_fd_pr__nfet_01v8  w=4e-6  l=150n  m=1
XMpF  comp2d_out  comp2c_out   vdd  vdd  sky130_fd_pr__pfet_01v8  w=12e-6 l=150n  m=1

* S&H 2: transparent during phi1 → samples comp2d_out → vdac2_q (holds during phi2)
Xtg_sh2  comp2d_out  vdac2_q  phi1  phi1b  vdd  vss  tg
Ch_dac2  vdac2_q  vss  10e-12
Rdac2    vdac2_q  vdac2  1

* ============================================================
* Initial Conditions
* Stage 1: same as proven 1st-order design
* Stage 2: start at mid-supply equilibrium
* ============================================================
.ic v(vint1_out)  = 1.0
.ic v(vint1_in)   = 0.9
.ic v(cs1_top)    = 0.9
.ic v(cs1_bot)    = 1.8
.ic v(comp1a_out) = 0.0
.ic v(comp1b_out) = 1.8
.ic v(comp1c_out) = 0.0
.ic v(comp1d_out) = 1.8
.ic v(vdac1_q)    = 1.8
.ic v(vdac1)      = 1.8

.ic v(vint2_out)  = 0.9
.ic v(vint2_in)   = 0.9
.ic v(cs2a_top)   = 1.0
.ic v(cs2a_bot)   = 1.8
.ic v(cs2b_bot)   = 1.8
.ic v(comp2a_out) = 0.0
.ic v(comp2b_out) = 1.8
.ic v(comp2c_out) = 0.0
.ic v(comp2d_out) = 1.8
.ic v(vdac2_q)    = 1.8
.ic v(vdac2)      = 1.8

* ============================================================
* Transient: 10ms = 10000 clock cycles
* ============================================================
.options RSHUNT=1e10 RELTOL=0.001 ABSTOL=1e-13 VNTOL=1e-4 ITL4=300

.control
tran 20n 10m uic

set wr_vecnames
set wr_singlescale
wrdata /tmp/adc_tran.dat v(vint1_out) v(vdac1_q) v(vdac2_q) v(vin) v(phi1) v(phi2)

quit
.endc

.end
