* 1st-order Switched-Capacitor Sigma-Delta ADC — Transistor Level
* SKY130 130nm CMOS, 1.8V supply
* fs=1MHz, OSR=64, fin=10kHz (EEG/ECG band)
*
* ARCHITECTURE:
*   Inverting SC integrator (samples Vin, subtracts Vdac into Ci)
*   + 2-inverter CMOS comparator (trip ≈ VDD/2 = 0.9V)
*   + TG sample-and-hold (samples comp output during phi1 → holds during phi2)
*   + 1-bit DAC = held comparator output (vdac_q)
*
* SIGN CONVENTION (inverting SC integrator, standard Fleischer-Laker):
*   Vout[n] = Vout[n-1] - (Cs/Ci)*(Vin[n-1] - Vdac[n-1])
*   = Vout[n-1] - 0.25*(Vin - Vdac)
*
*   When Vout > VCM: comp fires HIGH, Vdac=VDD, Δ=-(Vin-VDD)=+0.9/4=+0.225 (WRONG)
*
* ACTUALLY use a non-inverting SC integrator with bottom plate sampling:
*   phi1: cs_top=vin, cs_bot=vcmbias (sample)
*   phi2: cs_top=vcmbias, cs_bot=vdac (subtract DAC from integrator input)
*         OTA input = cs_bot switched to vdac
*
* SIMPLIFIED CORRECT TOPOLOGY:
*   Standard bottom-plate SC integrator:
*   phi1: bottom plate = Vdac (DAC reference)
*   phi2: bottom plate = virtual ground (VCM)
*   phi1: top plate = Vin (input)
*   phi2: top plate = VCM (reset top plate)
*   → Vout[n] = Vout[n-1] + (Cs/Ci)*(Vin - Vdac) ✓
*   When Vout > VCM: Vdac=VDD → (Vin-VDD)<0 → Vout decreases ✓ NEGATIVE FEEDBACK
*
* KEY INSIGHT for the correct SC integrator:
*   Bottom plate (cs_bot) connects to:
*     phi1: Vdac (set DAC reference)
*     phi2: OTA virtual ground (VCM)
*   Top plate (cs_top) connects to:
*     phi1: Vin (sample input)
*     phi2: VCM (reset top to common mode)
*   → Charge transferred = Cs*(Vin - Vdac) into OTA virtual ground ✓
* ============================================================

.lib sky130_models/sky130.lib.spice tt

* ============================================================
* Parameters
* ============================================================
.param VDD    = 1.8
.param VCM    = 0.9
.param Cs     = 3e-12    ; sampling cap 3pF  (α=Cs/Ci=0.75 → NTF=(1-z⁻¹)/(1-0.25z⁻¹))
.param Ci     = 4e-12    ; integration cap 4pF  (step=0.675V, stable range ±0.675V)

* OTA sizing (keeps same transistors as before)
.param p_wn_in   = 4e-6
.param p_ln_in   = 0.5e-6
.param p_wp_load = 4e-6
.param p_lp_load = 1e-6
.param p_wn_tail = 4e-6
.param p_ln_tail = 2e-6
* M5 2nd stage PMOS: need ID_M5 = ID_M6 for balanced output stage
* ID_M3=25µA (W/L=4), ID_M5 mirrors M3 with ratio (W/L_M5)/(W/L_M3) * m=2
* Need 100µA: (W5*2/L5) / (4/1) = 100/25=4 → W5*2/L5=16 → W5=4µm,L5=0.5µm,m=2 → W/L_eff=16
* ID_M6=100µA from vbn mirror (W=4µm,L=1µm vs Wbias=4µm,Lbias=2µm → ratio=2 → 2*50µA=100µA)
.param p_wp_2nd  = 4e-6
.param p_lp_2nd  = 0.5e-6
.param p_wn_2nd  = 4e-6
.param p_ln_2nd  = 1e-6
* Cc: stability with 4pF Ci load
.param p_cc      = 2e-12
* 50µA bias: gm1≈465µA/V, GBW=37MHz → fast settling <100ns
.param p_ibias   = 50e-6

* ============================================================
* Power supplies
* ============================================================
VDD  vdd  0  DC 1.8
VVSS vss  0  DC 0

* ============================================================
* Input: Vin = 0.9V + 0.35V*sin(2pi*1.5kHz*t)
* ============================================================
* fin=1.5kHz: sinc³ attenuation ≈ 0 (vs -4.4dB at 5kHz); amplitude 0.35V = 52% of 0.675V stability limit
* 100Ω prevents vin#branch convergence failures when phi1 switch charges sampling cap
Vin_src  vin_src  0  DC 0.9  SIN(0.9 0.35 1.5e3 0 0)
Rvin     vin_src  vin  100

* ============================================================
* Non-overlapping clocks (Ts=1us)
* phi1 HIGH: 0→490ns  phi2 HIGH: 510ns→1000ns  dead=20ns
* ============================================================
* 100Ω series resistors prevent infinite-current at switch transitions (prevents #branch convergence errors)
Vphi1  phi1_src  0  PULSE(0   1.8  0     2n 2n  486n  1u)
Vphi1b phi1b_src 0  PULSE(1.8 0    0     2n 2n  486n  1u)
Vphi2  phi2_src  0  PULSE(0   1.8  510n  2n 2n  486n  1u)
Vphi2b phi2b_src 0  PULSE(1.8 0    510n  2n 2n  486n  1u)
Rphi1  phi1_src  phi1  100
Rphi1b phi1b_src phi1b 100
Rphi2  phi2_src  phi2  100
Rphi2b phi2b_src phi2b 100

* ============================================================
* Bias for OTA
* ============================================================
* 100Ω series resistor prevents infinite-current spike at switch transitions (vcmbias#branch convergence fix)
Vcmbias vcmbias_src 0 DC 0.9
Rcmbias vcmbias_src vcmbias 100
Ibias  vdd  vbn  DC {p_ibias}
XMbias vbn  vbn  vss vss  sky130_fd_pr__nfet_01v8  w={p_wn_tail} l={p_ln_tail} m=1

* ============================================================
* OTA — Two-stage Miller-compensated
* Ports: vip vin vout vdd vss vbn
* ============================================================
.subckt ota  vip  vin  vout  vdd  vss  vbn
XMtail  ntail  vbn    vss  vss  sky130_fd_pr__nfet_01v8  w={p_wn_tail} l={p_ln_tail} m=1
XM1     nd1    vip    ntail vss  sky130_fd_pr__nfet_01v8  w={p_wn_in}   l={p_ln_in}   m=2
XM2     nd2    vin    ntail vss  sky130_fd_pr__nfet_01v8  w={p_wn_in}   l={p_ln_in}   m=2
XM3     nd1    nd1    vdd   vdd  sky130_fd_pr__pfet_01v8  w={p_wp_load} l={p_lp_load} m=1
XM4     nd2    nd1    vdd   vdd  sky130_fd_pr__pfet_01v8  w={p_wp_load} l={p_lp_load} m=1
XM5     vout   nd2    vdd   vdd  sky130_fd_pr__pfet_01v8  w={p_wp_2nd}  l={p_lp_2nd}  m=2
XM6     vout   vbn    vss   vss  sky130_fd_pr__nfet_01v8  w={p_wn_2nd}  l={p_ln_2nd}  m=1
* Null resistor Rz in series with Cc: with Rz=2200 > 1/gm_M5≈1920Ω, zero moves from RHP to LHP
* LHP zero at ~284MHz boosts PM to ~88° (vs ~30° without it)
Cc      nd2    cc_int {p_cc}
Rz      cc_int vout   2200
.ends ota

* ============================================================
* Transmission Gate — closed when ph=1
* ============================================================
.subckt tg  in  out  ph  phb  vdd  vss
* d g s b ordering: gate=clock, source/drain=signal path
XMN  in  ph   out  vss  sky130_fd_pr__nfet_01v8  w=1e-6  l=150n  m=1
XMP  in  phb  out  vdd  sky130_fd_pr__pfet_01v8  w=2e-6  l=150n  m=1
.ends tg

* ============================================================
* CORRECTED SC Integrator Topology
*
* CHARGE TRANSFER ANALYSIS:
* At end of phi1: Q_cs = Cs*(Vin - Vdac) [top=Vin, bot=Vdac]
* At end of phi2: Q_cs = Cs*(VCM - VCM) = 0 [top=VCM, bot=virtual ground=VCM]
* ΔQ into virtual ground (vint_in) = Q_cs_phi1 - Q_cs_phi2 = Cs*(Vin-Vdac)
* OTA responds: Δvint_out = (Cs/Ci)*(Vin-Vdac) ← NON-INVERTING INTEGRATOR
*
* NOTE: The OTA configured with V+ = fixed vcmbias = 0.9V,
*        V- = vint_in = virtual ground
* When ΔQ is injected INTO vint_in (vint_in rises → V- > V+):
*   OTA DECREASES output → vint_out DECREASES
*   Ci (from vint_in to vint_out) provides negative feedback ← WAIT IS THIS RIGHT?
*
* With Ci from vint_in (node A) to vint_out (node B):
*   Q_Ci = Ci*(V_A - V_B) = Ci*(vint_in - vint_out)
*   V_A = vint_in → fixed at VCM by OTA virtual ground
*   V_B = vint_out → adjusts to absorb charge
*
* If ΔQ+ is injected into vint_in (tends to rise): OTA drives vint_out DOWN
*   → V_B decreases → (V_A - V_B) increases → Q_Ci increases
*   → MORE charge on vint_in side of Ci → vint_in FURTHER INCREASES
*   → THIS IS POSITIVE FEEDBACK!
*
* The OTA inverting input IS inverting. The correct OTA for NEGATIVE FEEDBACK with
* Ci from virtual ground to output needs: increasing vint_in → increasing vout.
* This means: vip = vint_in (non-inverting input = virtual ground) [SWAP!]
*             vin = vcmbias (inverting input = fixed bias)
*
* CORRECTED: swap vip and vin in OTA:
*   Xota1 vint_in vcmbias vint_out vdd vss vbn ota
*   [vip = vint_in, vin = vcmbias = 0.9V]
*   When vint_in > vcmbias=0.9V → output INCREASES → Ci pushes vint_in UP → stable? NO
*
* Actually: for standard op-amp virtual ground at V- with negative feedback:
*   V+ = 0 (GND) or Vbias, V- = A (virtual ground), Vout = output
*   Feedback cap Ci from A to Vout
*   When charge injected into A (A rises above V+): Vout must DECREASE
*   As Vout decreases, (A - Vout) increases, Ci charges more → MORE current out of A → NEGATIVE FEEDBACK
*
* Wait: If Ci is from A to Vout, and Vout DECREASES:
*   Q_Ci = Ci*(A - Vout) INCREASES (A fixed, Vout decreases)
*   To increase Q_Ci, positive charge flows INTO A (from the charge supply to A)
*   But we want current to flow OUT OF A to reduce the overshoot...
*   Actually: the current balance is that external charge injected into A equals
*   the change in Ci charge plus any other currents.
*   KCL at A: Iinj + I_Ci_into_A = 0 (for ideal virtual ground A=const)
*   Iinj = positive (charge injected)
*   I_Ci_into_A = -Iinj = negative (current flows FROM A through Ci to Vout)
*   This means current flows FROM A (virtual ground) THROUGH Ci TO VOUT
*   → Ci charges from A to Vout: positive charge leaves A, negative charge enters A
*   → Q_Ci = Ci*(A - Vout) is NOT changing... hmm
*
* I think the confusion is between op-amp sign conventions. Let me just use:
*   Standard inverting op-amp: V+ = GND (0), V- = A (virtual ground), Vout
*   Ci from A to Vout: as Vout goes NEGATIVE (when A is positive), Q_Ci increases
*   KCL: Iinj (into A) + d(Q_Ci_at_A)/dt = 0
*   d(Q_Ci)/dt = Ci * d(A-Vout)/dt ≈ -Ci * dVout/dt (since A ≈ 0 = constant)
*   → Ci * (-dVout/dt) = -Iinj → dVout/dt = Iinj/Ci → Vout INTEGRATES Iinj ✓
*   → Vout increases when Iinj > 0 → NON-INVERTING w.r.t. input current!
*   → But OTA output: V+>V- → Vout increases... so OTA with V+ = GND, V- = A:
*      When Iinj>0 → A rises → V+ > V- ... no V+ = GND, V- = A > 0 → Vout DECREASES
*      → Vout DECREASES when A increases → INVERTING!
*   Contradiction with the charge analysis above... I must have a sign error.
*
* ========= FINAL RESOLUTION =========
* Use SPICE directly with a behavioral B-source to verify, then replace.
* For now, use the KNOWN WORKING topology from textbooks:
*   - Standard non-inverting SC integrator (Cs bottom plate = Vdac at phi1)
*   - The OTA with V+ at virtual ground node, V- at fixed bias
*   - This gives Vout[n] = Vout[n-1] + (Cs/Ci)*(Vin - Vdac) ✓
*
* ============================================================

* phi1: top=Vin, bottom=Vdac
* phi2: top=VCM, bottom=virtual ground (vint_in)
* OTA: vip=vint_in (non-inverting INPUT = virtual ground), vin=vcmbias (fixed bias)
* Note: reversed from before! This gives non-inverting integrator response.

* phi1 switches (sample Vin onto Cs, bottom plate sampled with Vdac)
Xs1a  vin      cs_top  phi1  phi1b  vdd  vss  tg
Xs1b  vdac     cs_bot  phi1  phi1b  vdd  vss  tg

* phi2 switches (charge transfer: top=VCM, bottom=virtual ground)
Xs2a  vcmbias  cs_top  phi2  phi2b  vdd  vss  tg
Xs2b  vint_in  cs_bot  phi2  phi2b  vdd  vss  tg

* Sampling cap
Csamp  cs_top  cs_bot  {Cs}

* OTA: non-inverting input = vint_in (virtual ground here), inverting = vcmbias
* NOTE: vip=vint_in, vin=vcmbias → when vint_in > vcmbias → output increases
* This makes Ci (vint_in to vint_out) create positive feedback... unless...
*
* Let me use the SIMPLEST POSSIBLE OTA configuration that works:
* OTA as a follower: vip=some_ref, vin=output_feedback, vout = output
* For the integrator: the output needs to INTEGRATE the input current
* Use: vip=vcmbias, vin=vint_in, vout=vint_out
* Ci: from vint_OUT to vint_IN (reversed compared to before)
* This gives: when charge into vint_in → vint_in rises → vin > vip → vout FALLS
*             → Ci (from vout to vin): Q_Ci = Ci*(vout-vin) → decreasing
*             → current flows INTO vint_in from Ci = Ci*dvout/dt > 0...
*
* I give up trying to derive this analytically. Just swap OTA inputs and cap orientation
* to the known-working configuration.
*
* KNOWN WORKING (from standard textbooks):
* OTA: V+ = VCM (fixed), V- = virtual_gnd, Vout
* Ci: from Vout to virtual_gnd (Ci from OUTPUT to INVERTING input)
* → `Ci_int vint_out vint_in {Ci}` [first node = vint_out, second = vint_in]
* → OTA: Xota1 vcmbias vint_in vint_out vdd vss vbn ota (same as before)
*
* And SC switches:
* phi1: cs_top=Vin, cs_bot=Vdac
* phi2: cs_top=VCM, cs_bot=vint_in

* OTA: port1("vip") is actually INVERTING (M1 gate → output falls when vip rises)
*      → vint_in at port1 = inverting input → NEGATIVE feedback ✓
*      → vcmbias at port2 = non-inverting input (reference) ✓
Xota1  vint_in  vcmbias  vint_out  vdd  vss  vbn  ota

* Integration cap: FROM OUTPUT to INPUT (key fix from before)
Ci_int  vint_out  vint_in  {Ci}

* ============================================================
* Comparator: 2-inverter chain + TG S&H
* Transparent during phi1 (when S2 is open, DAC change doesn't matter)
* Holds during phi2 (provides stable Vdac for integration)
* ============================================================

* TWO-INVERTER COMPARATOR: total response is NON-INVERTING
* The SC integrator is NON-INVERTING (Δvout = +(Cs/Ci)*(Vin-Vdac)).
* A single inverter + NON-INVERTING integrator → POSITIVE feedback (wrong).
* Two inverters give NON-INVERTING comparator path:
*   vint_out > 0.9V → comp_out=LOW → comp2_out=HIGH → vdac=1.8V
*   → Δvint = +(Cs/Ci)*(Vin-1.8) < 0 → vint DECREASES ← NEGATIVE FEEDBACK ✓
* SKY130: µn/µp ≈ 3.2 → Wp ≈ 3.2*Wn for trip≈0.9V, Wn=4µm, Wp=12µm
XMnA  comp_out   vint_out   vss  vss  sky130_fd_pr__nfet_01v8  w=4e-6  l=150n  m=1
XMpA  comp_out   vint_out   vdd  vdd  sky130_fd_pr__pfet_01v8  w=12e-6 l=150n  m=1
XMnB  comp2_out  comp_out   vss  vss  sky130_fd_pr__nfet_01v8  w=4e-6  l=150n  m=1
XMpB  comp2_out  comp_out   vdd  vdd  sky130_fd_pr__pfet_01v8  w=12e-6 l=150n  m=1

* TG S&H: transparent during phi1 (phi1=1 → TG open)
* Samples comp2_out (NON-INVERTING total) during phi1, holds during phi2
Xtg_sh  comp2_out  vdac_q  phi1  phi1b  vdd  vss  tg

* Hold cap (10pF, clamps Vdac excursions from clock injection; settling still fast: 5pF*400Ω≈2ns << 488ns)
Ch_dac  vdac_q  vss  10e-12

* DAC = vdac_q directly (1Ω isolation resistor for convergence)
Rdac  vdac_q  vdac  1

* ============================================================
* Initial Conditions — CORRECTED for NON-INVERTING SC + double-inverter path
*
* vint_out=1.0V > 0.9V → inv1: comp_out=LOW(0V) → inv2: comp2_out=HIGH(1.8V)
*   → vdac_q=1.8V → vdac=1.8V
* First phi2: Δvint = +(Cs/Ci)*(Vin-Vdac) = +0.75*(0.9-1.8) = -0.675V
*   → vint_out = 0.325V < 0.9V → comp_out=HIGH → comp2_out=LOW → vdac=0V
* Second phi2: Δvint = +0.75*(0.9-0) = +0.675V → vint_out=1.0V → oscillation ✓
*   density_1 = Vin/VDD = 0.5 at Vin=0.9V ✓ (α=0.75)
* ============================================================
.ic v(vint_out)  = 1.0
.ic v(vint_in)   = 0.9
.ic v(cs_top)    = 0.9
.ic v(cs_bot)    = 1.8
.ic v(vdac)      = 1.8
.ic v(vdac_q)    = 1.8
.ic v(comp_out)  = 0.0
.ic v(comp2_out) = 1.8

* ============================================================
* Transient: 10ms = 10000 clock cycles at OSR=64 → 153 SINC decimated samples
* ============================================================
* RSHUNT=1e10: 10GΩ to GND on all nodes prevents floating-node singularity in SC circuits
* RELTOL/VNTOL relaxed for fast switching transitions
.options RSHUNT=1e10 RELTOL=0.01 ABSTOL=1e-12 VNTOL=1e-3 ITL4=200

.control
* 10ms @ 20ns max step → ~10000 clock cycles → ~153 decimated samples (OSR=64, SINC3 filter delay=190)
tran 20n 10m uic

set wr_vecnames
set wr_singlescale
wrdata /tmp/adc_tran.dat v(vint_out) v(vdac_q) v(vin) v(phi1) v(phi2) v(comp_out)

quit
.endc

.end
