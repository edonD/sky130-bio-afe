* Debug bandgap OTA operating point
.param p_wp_pass = 10e-6
.param p_lp_pass = 1e-6
.param p_ra_l = 111e-6
.param p_rptat_l = 12e-6
.param p_r_w = 0.69e-6
.param p_nbjt = 8
.param p_wn_ota = 2e-6
.param p_ln_ota = 4e-6
.param p_wp_ota = 4e-6
.param p_lp_ota = 4e-6
.param p_wn_cas = 2e-6
.param p_ln_cas = 1e-6
.param p_wp_cas = 4e-6
.param p_lp_cas = 1e-6
.param p_wn_tail = 1e-6
.param p_ln_tail = 8e-6
.param p_cap = 5e-12

VDD vdd 0 DC 1.8
VSS vss 0 DC 0

XMP_pass vref opamp_out vdd vdd sky130_fd_pr__pfet_01v8 w={p_wp_pass} l={p_lp_pass} m=4
XRa vref node_a vss sky130_fd_pr__res_xhigh_po_0p69 w={p_r_w} l={p_ra_l} mult=1
XQ1 vss vss node_a vss sky130_fd_pr__pnp_05v5_w3p40l3p40 m=1
XRb vref node_b vss sky130_fd_pr__res_xhigh_po_0p69 w={p_r_w} l={p_ra_l} mult=1
XRptat node_b eb vss sky130_fd_pr__res_xhigh_po_0p69 w={p_r_w} l={p_rptat_l} mult=1
XQ2 vss vss eb vss sky130_fd_pr__pnp_05v5_w3p40l3p40 m={p_nbjt}
XMS1 vref startup_n vdd vdd sky130_fd_pr__pfet_01v8 w=0.42e-6 l=4e-6 m=1
XMS_invp startup_n vref vdd vdd sky130_fd_pr__pfet_01v8 w=0.42e-6 l=0.15e-6 m=1
XMS_invn startup_n vref vss vss sky130_fd_pr__nfet_01v8 w=0.42e-6 l=4e-6 m=1
Cvref vref vss {p_cap}

XMN_bias ota_bias ota_bias vss vss sky130_fd_pr__nfet_01v8 w={p_wn_tail} l={p_ln_tail} m=1
XMN_tail ota_tail ota_bias vss vss sky130_fd_pr__nfet_01v8 w={p_wn_tail} l={p_ln_tail} m=1
XRbias vdd ota_bias vss sky130_fd_pr__res_xhigh_po_0p69 w={p_r_w} l=500e-6 mult=1

XMN_p ota_dn node_b ota_tail vss sky130_fd_pr__nfet_01v8 w={p_wn_ota} l={p_ln_ota} m=1
XMN_n ota_dp node_a ota_tail vss sky130_fd_pr__nfet_01v8 w={p_wn_ota} l={p_ln_ota} m=1

XMN_cbias ncbias ncbias vss vss sky130_fd_pr__nfet_01v8 w={p_wn_cas} l={p_ln_cas} m=1
XRcbias vdd ncbias vss sky130_fd_pr__res_xhigh_po_0p69 w={p_r_w} l=200e-6 mult=1
XMN_cp ota_cn ncbias ota_dn vss sky130_fd_pr__nfet_01v8 w={p_wn_cas} l={p_ln_cas} m=1
XMN_cn ota_outp ncbias ota_dp vss sky130_fd_pr__nfet_01v8 w={p_wn_cas} l={p_ln_cas} m=1

XMP_ln ota_cn ota_cn vdd vdd sky130_fd_pr__pfet_01v8 w={p_wp_ota} l={p_lp_ota} m=1
XMP_lp ota_outp ota_cn vdd vdd sky130_fd_pr__pfet_01v8 w={p_wp_ota} l={p_lp_ota} m=1

Rcomp ota_outp opamp_out 10k
Ccomp opamp_out vss 2p

.lib "sky130_models/sky130.lib.spice" tt
.option reltol=0.003 abstol=1e-12 gmin=1e-12 method=gear
.option itl1=500 itl2=200 rshunt=1e9
.nodeset v(vref)=1.16 v(node_a)=0.69 v(node_b)=0.69 v(opamp_out)=1.3
+ v(ota_cn)=0.7 v(ota_outp)=0.7 v(ota_tail)=0.05 v(ota_bias)=0.8
+ v(eb)=0.64 v(ota_dn)=0.4 v(ota_dp)=0.4

.control
op
print all
quit
.endc

.end
