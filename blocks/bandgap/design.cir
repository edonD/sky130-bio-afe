* SKY130 Bandgap Voltage Reference — Classic Self-Biased BGR
*
* Topology:
*   PMOS current mirror (MP1 diode-connected, MP2/MP3 copies)
*   Branch 1: MP1 -> Q1 (1x PNP) -> GND  [Vdrain1 = Vbe1]
*   Branch 2: MP2 -> Rptat -> Q2 (Nx PNP) -> GND  [Vdrain2 = I*Rptat + Vbe2]
*   Mirror forces I1 = I2 => Vbe1 - Vbe2 = I*Rptat => I = Vt*ln(N)/Rptat
*   Output:   MP3 -> Rout -> Q3 (1x PNP) -> GND => V_REF = I*Rout + Vbe3
*
*   V_REF = Vbe3 + (Rout/Rptat) * Vt * ln(N)
*   At zero TC: (Rout/Rptat) * ln(N) ≈ (Vgo - Vbe)/(Vt) ≈ 17.2 for Vbe≈0.65V
*   With N=8, ln(8)=2.079: Rout/Rptat ≈ 17.2/2.079 ≈ 8.27
*
* === Parameters ===
.param p_wp = 4e-6
.param p_lp = 4e-6
.param p_mp = 2
.param p_rptat_l = 15e-6
.param p_rout_l = 120e-6
.param p_r_w = 0.69e-6
.param p_nbjt = 8
.param p_cap = 3e-12
.param p_wn_start = 0.42e-6
.param p_ln_start = 10e-6

* === Power Supply ===
VDD vdd 0 DC 1.8
VSS vss 0 DC 0

* === PMOS Current Mirror ===
* MP1: diode-connected (sets gate voltage)
XMP1 d1 d1 vdd vdd sky130_fd_pr__pfet_01v8 w={p_wp} l={p_lp} m={p_mp}
* MP2: copy for PTAT branch
XMP2 d2 d1 vdd vdd sky130_fd_pr__pfet_01v8 w={p_wp} l={p_lp} m={p_mp}
* MP3: copy for output branch
XMP3 d3 d1 vdd vdd sky130_fd_pr__pfet_01v8 w={p_wp} l={p_lp} m={p_mp}

* === Branch 1: Q1 (1x PNP, diode-connected) ===
* d1 -> Q1 emitter -> GND (collector and base tied to GND)
XQ1 vss vss d1 vss sky130_fd_pr__pnp_05v5_w3p40l3p40 m=1

* === Branch 2: Rptat + Q2 (Nx PNP) ===
* d2 -> Rptat -> Q2 emitter -> GND
XRptat d2 e2 vss sky130_fd_pr__res_xhigh_po_0p69 w={p_r_w} l={p_rptat_l} mult=1
XQ2 vss vss e2 vss sky130_fd_pr__pnp_05v5_w3p40l3p40 m={p_nbjt}

* === Output Branch: Rout + Q3 (1x PNP) ===
* d3 -> Rout -> Q3 emitter -> GND
* V_REF = V(d3) = I*Rout + Vbe3
XRout d3 e3 vss sky130_fd_pr__res_xhigh_po_0p69 w={p_r_w} l={p_rout_l} mult=1
XQ3 vss vss e3 vss sky130_fd_pr__pnp_05v5_w3p40l3p40 m=1

* Output node
Rvref d3 vref 0.01
Cvref vref vss {p_cap}

* === Startup Circuit ===
* Problem: zero-current state is stable (MP gate at VDD, all off)
* Solution: weak NFET pulls d1 low when circuit is off
* When d1 is near 0V (circuit off), gate of startup NFET = vdd => on => pulls d1 low
* This forces MP1 gate low => turns on mirrors => circuit starts
* Once started, d1 = Vbe ≈ 0.7V. Startup NFET sees Vds ≈ 0.7V, Vgs = Vdd - 0 = 1.8V
* Hmm, startup NFET will still be on... Need to disable it.
*
* Better startup: Use PMOS that senses vref or d1 being high
* When circuit is off, vref=0 => PMOS startup has Vgs = 0-VDD = -1.8V => ON => injects current
* When circuit starts, vref ≈ 1.2V => Vgs = 1.2-1.8 = -0.6V ≈ Vtp => barely on/off
* Use a long-channel weak PMOS
XMP_start d1 vref vdd vdd sky130_fd_pr__pfet_01v8 w=0.42e-6 l=8e-6 m=1

* === Simulation Control ===
.lib "sky130_models/sky130.lib.spice" tt
.option reltol=0.003 abstol=1e-12 gmin=1e-12 method=gear
.nodeset v(d1)=0.7 v(d2)=0.75 v(d3)=1.2 v(vref)=1.2

.control
op
print v(vref) v(d1) v(d2) v(d3) v(e2) v(e3)
print @VDD[i]
quit
.endc

.end
