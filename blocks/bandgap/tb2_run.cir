* SKY130 Bandgap Voltage Reference — V2
*
* Voltage-mode (Banba-like) with PMOS pass transistor.
* V_REF = Vt*ln(N)*Ra/Rptat + Vbe1

* === Parameters ===
.param p_wp_pass = 20e-6
.param p_lp_pass = 1e-6
.param p_ra_l = 122e-6
.param p_rptat_l = 12.5e-6
.param p_r_w = 0.69e-6
.param p_nbjt = 8
.param p_wn_ota = 2e-6
.param p_ln_ota = 3e-6
.param p_wp_ota = 2e-6
.param p_lp_ota = 5e-6
.param p_wn_tail = 1e-6
.param p_ln_tail = 4e-6
.param p_cap = 5e-12

* === Power Supply ===
VDD vdd 0 DC 1.8
VSS vss 0 DC 0

* === PMOS Pass Transistor ===
XMP_pass vref opamp_out vdd vdd sky130_fd_pr__pfet_01v8 w={p_wp_pass} l={p_lp_pass} m=4

* === Branch A: Ra + Q1 (1x PNP) ===
XRa vref node_a vss sky130_fd_pr__res_xhigh_po_0p69 w={p_r_w} l={p_ra_l} mult=1
XQ1 vss vss node_a vss sky130_fd_pr__pnp_05v5_w3p40l3p40 m=1

* === Branch B: Rb (=Ra) + Rptat + Q2 (Nx PNP) ===
XRb vref node_b vss sky130_fd_pr__res_xhigh_po_0p69 w={p_r_w} l={p_ra_l} mult=1
XRptat node_b eb vss sky130_fd_pr__res_xhigh_po_0p69 w={p_r_w} l={p_rptat_l} mult=1
XQ2 vss vss eb vss sky130_fd_pr__pnp_05v5_w3p40l3p40 m={p_nbjt}

* Output filter cap
Cvref vref vss {p_cap}

* === OTA (NFET diff pair, PMOS active load) ===
XMN_bias ota_bias ota_bias vss vss sky130_fd_pr__nfet_01v8 w={p_wn_tail} l={p_ln_tail} m=1
XMN_tail ota_tail ota_bias vss vss sky130_fd_pr__nfet_01v8 w={p_wn_tail} l={p_ln_tail} m=1
XRbias vdd ota_bias vss sky130_fd_pr__res_xhigh_po_0p69 w={p_r_w} l=350e-6 mult=1

* Diff pair
XMN_p ota_outn node_b ota_tail vss sky130_fd_pr__nfet_01v8 w={p_wn_ota} l={p_ln_ota} m=1
XMN_n ota_outp node_a ota_tail vss sky130_fd_pr__nfet_01v8 w={p_wn_ota} l={p_ln_ota} m=1

* PMOS active load
XMP_ln ota_outn ota_outn vdd vdd sky130_fd_pr__pfet_01v8 w={p_wp_ota} l={p_lp_ota} m=1
XMP_lp ota_outp ota_outn vdd vdd sky130_fd_pr__pfet_01v8 w={p_wp_ota} l={p_lp_ota} m=1

* Compensation
Rcomp ota_outp opamp_out 8k
Ccomp opamp_out vss 2p

* === Simulation Control ===
.lib "sky130_models/sky130.lib.spice" tt
.option reltol=0.003 abstol=1e-12 gmin=1e-12 method=gear
.option itl1=500 itl2=200 rshunt=1e9
.nodeset v(vref)=1.16 v(node_a)=0.69 v(node_b)=0.69 v(opamp_out)=1.3
+ v(ota_outn)=0.7 v(ota_outp)=0.7 v(ota_tail)=0.05 v(ota_bias)=0.8
+ v(eb)=0.64

.control
dc temp 125 -40 -1
wrdata /home/ubuntu/workspace/sky130-bio-afe/blocks/bandgap/tb2_data v(vref)
quit
.endc
.end
