* SKY130 Bandgap Voltage Reference — Kuijk/Voltage-Mode Topology
*
* V_REF is the direct output of an op-amp, giving inherent PSRR.
* The op-amp drives V_REF which splits into two branches through resistors:
*   Branch A: V_REF -> Ra -> Q1(1x) -> GND  [Va = V_REF - I_a*Ra]
*   Branch B: V_REF -> Rb -> Rptat -> Q2(8x) -> GND  [Vb = V_REF - I_b*(Rb+Rptat)]
*
* Op-amp forces Va = Vb (at nodes a,b below the resistors):
*   I_a*Ra + Vbe1 = 0 (Va = Vbe1, relative to V_REF)...
*
* Actually, let me use the standard Kuijk topology:
* Op-amp output = V_REF. Two resistor-BJT branches from V_REF:
*   Branch A: V_REF -> Ra -> node_a  -> Q1(1x) -> GND
*   Branch B: V_REF -> Rb -> node_b -> Rptat -> Q2(8x) -> GND
*   Op-amp: + = node_a, - = node_b -> output = V_REF
*
*   Forces node_a = node_b:
*   V_REF - I_a*Ra = Vbe1 (since node_a = Vbe1)
*   V_REF - I_b*Rb = I_b*Rptat + Vbe2 (since node_b = I_b*Rptat + Vbe2)
*
*   With Ra = Rb and I_a = I_b (from equal node voltages and matched R):
*   NOT exactly right... the currents aren't necessarily equal.
*
* Simpler: use PMOS current sources from V_REF instead of resistors.
* Or use the conventional approach with the op-amp sourcing current.
*
* REVISED: Op-amp output drives PMOS pass transistor (LDO-like)
*   PMOS pass: gate = opamp_out, source = VDD, drain = V_REF
*   V_REF feeds two branches through matched resistors:
*     Branch A: V_REF -> Ra -> Q1(1x) -> GND  [I_a = (V_REF - Vbe1)/Ra]
*     Branch B: V_REF -> Rb -> Q2(8x) -> GND  [I_b = (V_REF - Vbe2)/Rb]
*
*   Op-amp compares: + = junction of Ra&Q1, - = junction of Rb&Q2
*   Actually no, that's comparing Vbe1 and Vbe2...
*
* Let me use the Brokaw cell adapted for substrate PNPs:
* Since substrate PNPs have collector = GND, the classic Brokaw needs adaptation.
*
* FINAL: Simple voltage-mode BGR with PMOS output stage
*   - PMOS pass transistor: source = VDD, gate = opamp_out, drain = V_REF
*   - From V_REF: two branches to GND
*   - Branch A: Ra + Q1(1x)
*   - Branch B: Rb + Rptat + Q2(Nx) [Rb matched to Ra]
*   - Op-amp: + = top of Q1 (= Vbe1), - = top of Rptat+Q2 (= I*Rptat + Vbe2)
*   - Wait, this is the same as Banba but with a PMOS pass instead of mirror
*
*   Forces: Vbe1 = I*Rptat + Vbe2 (with Ra=Rb, currents equal from same V_REF)
*   I = dVbe/Rptat = Vt*ln(N)/Rptat (same bandgap current)
*   V_REF = I*Ra + Vbe1 = Vt*ln(N)*Ra/Rptat + Vbe1
*
*   PSRR: V_REF is the output of the PMOS pass transistor.
*   The op-amp regulates V_REF directly. VDD changes are rejected by
*   the op-amp loop gain. PSRR ≈ loop_gain (typically >60 dB).

* === Parameters ===
.param p_wp_pass = 8e-6
.param p_lp_pass = 1e-6
.param p_ra_l = 120e-6
.param p_rptat_l = 12e-6
.param p_r_w = 0.69e-6
.param p_nbjt = 8
.param p_wn_ota = 2e-6
.param p_ln_ota = 2e-6
.param p_wp_ota = 2e-6
.param p_lp_ota = 4e-6
.param p_wn_tail = 1e-6
.param p_ln_tail = 4e-6
.param p_cap = 5e-12

* === Power Supply ===
VDD vdd 0 PWL(0 0 10u 1.8 200u 1.8)
VSS vss 0 DC 0

* === PMOS Pass Transistor (LDO-style output) ===
* Gate driven by op-amp output. V_REF is the regulated output.
* PMOS pass transistor (standard Vt)
XMP_pass vref opamp_out vdd vdd sky130_fd_pr__pfet_01v8 w={p_wp_pass} l={p_lp_pass} m=4

* === Branch A: Ra + Q1 (1x PNP) ===
* Current I_a = (V_REF - Vbe1) / Ra
XRa vref node_a vss sky130_fd_pr__res_xhigh_po_0p69 w={p_r_w} l={p_ra_l} mult=1
XQ1 vss vss node_a vss sky130_fd_pr__pnp_05v5_w3p40l3p40 m=1

* === Branch B: Rb (matched to Ra) + Rptat + Q2 (Nx PNP) ===
* Current I_b = (V_REF - Vbe2 - I_b*Rptat) / Rb
XRb vref node_b vss sky130_fd_pr__res_xhigh_po_0p69 w={p_r_w} l={p_ra_l} mult=1
XRptat node_b eb vss sky130_fd_pr__res_xhigh_po_0p69 w={p_r_w} l={p_rptat_l} mult=1
XQ2 vss vss eb vss sky130_fd_pr__pnp_05v5_w3p40l3p40 m={p_nbjt}

* Output filter cap and startup
Cvref vref vss {p_cap}
* Weak startup: ensures V_REF > 0 at power-up so op-amp can function
* Also helps convergence during DC sweeps
* No startup circuit — rely on .nodeset for DC convergence
* The op-amp loop will maintain the bandgap state once converged

* === Op-Amp (NFET diff pair, PMOS load) ===
* + = node_a (Vbe1 ≈ 0.69V), - = node_b (I*Rptat + Vbe2 ≈ 0.69V)
* Output drives PMOS pass gate
* When node_a > node_b: more current needed, opamp_out drops, PMOS ON more, V_REF rises

* Tail bias (from VDD through resistor)
XMN_bias ota_bias ota_bias vss vss sky130_fd_pr__nfet_01v8 w={p_wn_tail} l={p_ln_tail} m=1
XMN_tail ota_tail ota_bias vss vss sky130_fd_pr__nfet_01v8 w={p_wn_tail} l={p_ln_tail} m=1
XRbias vdd ota_bias vss sky130_fd_pr__res_xhigh_po_0p69 w={p_r_w} l=400e-6 mult=1

* Diff pair: + = node_b, - = node_a (node_b > node_a → output UP → PMOS OFF)
XMN_p ota_outn node_b ota_tail vss sky130_fd_pr__nfet_01v8 w={p_wn_ota} l={p_ln_ota} m=1
XMN_n ota_outp node_a ota_tail vss sky130_fd_pr__nfet_01v8 w={p_wn_ota} l={p_ln_ota} m=1

* PMOS active load
XMP_ln ota_outn ota_outn vdd vdd sky130_fd_pr__pfet_01v8 w={p_wp_ota} l={p_lp_ota} m=1
XMP_lp ota_outp ota_outn vdd vdd sky130_fd_pr__pfet_01v8 w={p_wp_ota} l={p_lp_ota} m=1

* Op-amp output to PMOS pass gate
Rcomp ota_outp opamp_out 10k
Ccomp opamp_out vss 1p

* === Simulation Control ===
.lib "sky130_models/sky130.lib.spice" tt
.option reltol=0.003 abstol=1e-12 gmin=1e-12 method=gear
.option itl1=500 itl2=200 rshunt=1e9
* Strong initial conditions for convergence across temperature
.nodeset v(vref)=1.16 v(node_a)=0.69 v(node_b)=0.69 v(opamp_out)=1.3
+ v(ota_outn)=0.7 v(ota_outp)=0.7 v(ota_tail)=0.05 v(ota_bias)=0.8
+ v(eb)=0.64

.control
tran 0.1u 200u
wrdata /home/ubuntu/workspace/sky130-bio-afe/blocks/bandgap/startup_tran v(vref) v(vdd)
quit
.endc

.end
