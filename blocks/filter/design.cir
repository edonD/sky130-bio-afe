* SKY130 Bandpass Filter — Iteration 4
* Architecture: HPF (ideal R feedback) + 4th-order Sallen-Key Butterworth LPF
* Changes from iter3:
*   - Increase HPF feedback R: 10GΩ → 100GΩ (move f_low to 0.03 Hz, eliminates
*     passband ripple from HPF rolloff near 0.5 Hz)
*   - Reduce M7 stage-2 current: W=4u→2u (halve output stage current → ~9 µW)
*   - Increase diff pair W: 4u→8u (reduce flicker noise)
*   - Reduce M6 width: 32u→16u (save power, still adequate drive)

.lib "/home/ubuntu/workspace/sky130_models/sky130.lib.spice" tt

.param vdd_val = 1.8
.param vcm_val = 0.9

**********************************************
* SUPPLY AND BIAS
**********************************************
Vdd vdd 0 {vdd_val}
Vss vss 0 0
Vcm vcm 0 {vcm_val}

* Bias: ~500 nA reference
Rbias vdd nbias 2.2Meg
Xbias_n nbias nbias vss vss sky130_fd_pr__nfet_01v8 w=2u l=4u

**********************************************
* TWO-STAGE MILLER OPAMP
**********************************************
.subckt miller_opamp inp inn out vdd vss nbias
* PMOS mirror load
XM3 s1out s1mir vdd vdd sky130_fd_pr__pfet_01v8 w=4u l=2u
XM4 s1mir s1mir vdd vdd sky130_fd_pr__pfet_01v8 w=4u l=2u
* NMOS diff pair — wider for less noise
XM1 s1out inp tail1 vss sky130_fd_pr__nfet_01v8 w=8u l=1u
XM2 s1mir inn tail1 vss sky130_fd_pr__nfet_01v8 w=8u l=1u
* Tail current ~500 nA
XM5 tail1 nbias vss vss sky130_fd_pr__nfet_01v8 w=2u l=4u
* Stage 2: PMOS CS driver (reduced width for lower power)
XM6 out s1out vdd vdd sky130_fd_pr__pfet_01v8 w=16u l=0.5u
* Stage 2 current source — reduced W for lower power (~1 µA)
XM7 out nbias vss vss sky130_fd_pr__nfet_01v8 w=2u l=2u
* Miller compensation
Cc s1out out 50p
.ends miller_opamp

**********************************************
* PSEUDO-RESISTOR (ideal for now)
**********************************************
* 100 GΩ → f_low = 1/(2*pi*100G*50p) = 0.032 Hz
* Gain at 0.5 Hz: 1/sqrt(1+(0.032/0.5)^2) = 0.998 → -0.02 dB
* This eliminates the HPF contribution to passband ripple at 0.5 Hz
.subckt pseudo_res a b vdd
Rpr a b 100G
.ends pseudo_res

**********************************************
* STAGE 1: HIGH-PASS FILTER (1st order)
**********************************************
C_in input hpf_in 50p ic=0
Xpr_fb hpf_in hpf_out vdd pseudo_res
C_fb hpf_in hpf_out 50p ic=0
Xamp1 vcm hpf_in hpf_out vdd vss nbias miller_opamp

**********************************************
* STAGE 2: 4th-order Sallen-Key Butterworth LPF
**********************************************
* R = 10 MΩ, pF-range caps for opamp compatibility
*
* Section 1 (Q=0.5412, f0≈145 Hz):
* C1=120pF, C2=100pF, R=10MΩ
R_s1a hpf_out s1_mid 10Meg
R_s1b s1_mid s1_buf 10Meg
C_s1a s1_mid s1_out 120p
C_s1b s1_buf vcm 100p
Xamp2 s1_buf s1_out s1_out vdd vss nbias miller_opamp

* Section 2 (Q=1.3066, f0≈140 Hz):
* C1=300pF, C2=43pF, R=10MΩ
R_s2a s1_out s2_mid 10Meg
R_s2b s2_mid s2_buf 10Meg
C_s2a s2_mid s2_out 300p
C_s2b s2_buf vcm 43p
Xamp3 s2_buf s2_out s2_out vdd vss nbias miller_opamp

**********************************************
* OUTPUT
**********************************************
Rout s2_out output 100

**********************************************
* INPUT SOURCE
**********************************************
Vin input vcm dc 0 ac 1

.end
