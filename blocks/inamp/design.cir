* SKY130 Instrumentation Amplifier — Capacitively-Coupled OTA
* Topology: Fully-differential folded-cascode OTA with capacitive feedback
* Gain = Cin/Cfb ~ 50 V/V (34 dB)
*
* Architecture:
* - Input caps (Cin) AC-couple the signal, rejecting DC electrode offset
* - Feedback caps (Cfb) set closed-loop gain
* - Pseudo-resistors (large R) set DC bias of OTA inputs and HPF cutoff
* - PMOS input pair for low 1/f noise
* - Folded-cascode for high open-loop gain
* - Ideal CMFB for baseline simplicity

.lib "/home/ubuntu/workspace/sky130_models/sky130.lib.spice" tt

.param vdd_val = 1.8
.param vcm_val = 0.9
.param ibias_val = 2u

* ============================================================
* Tunable parameters
* ============================================================
.param wp_in = 50u       ; Input PMOS pair W (large for low 1/f noise)
.param lp_in = 2u        ; Input PMOS pair L (long for low 1/f noise)
.param wn_load = 5u      ; NMOS load W
.param ln_load = 2u      ; NMOS load L
.param wp_tail = 10u     ; PMOS tail current source W
.param lp_tail = 2u      ; PMOS tail current source L
.param cin_val = 10p     ; Input coupling capacitor
.param cfb_val = 200f    ; Feedback cap (gain = cin/cfb = 50)
.param rpseudo = 500G    ; Pseudo-resistor for DC bias

* ============================================================
* Supply
* ============================================================
VDD vdd 0 {vdd_val}

* ============================================================
* Bias generation (ideal current sources for baseline)
* ============================================================
* Tail current for input pair
Itail vdd tail {ibias_val*2}

* NMOS load bias - diode + mirror
Ibias_n vdd nbias {ibias_val}
Xbias_n nbias nbias 0 0 sky130_fd_pr__nfet_01v8 w={wn_load} l={ln_load}

* ============================================================
* PMOS Input Differential Pair
* ============================================================
Xm1 d1 inn_n tail vdd sky130_fd_pr__pfet_01v8 w={wp_in} l={lp_in}
Xm2 d2 inn_p tail vdd sky130_fd_pr__pfet_01v8 w={wp_in} l={lp_in}

* ============================================================
* NMOS Active Load (current mirror)
* ============================================================
* M3 diode-connected, M4 mirrors
Xm3 d1 d1 0 0 sky130_fd_pr__nfet_01v8 w={wn_load} l={ln_load}
Xm4 d2 d1 0 0 sky130_fd_pr__nfet_01v8 w={wn_load} l={ln_load}

* ============================================================
* Input Coupling Capacitors
* ============================================================
Cin_p inp inn_p {cin_val}
Cin_n inn inn_n {cin_val}

* ============================================================
* DC Bias for OTA Inputs (pseudo-resistors)
* ============================================================
* These set the DC operating point and define HPF cutoff
* f_HPF = 1/(2*pi*Rpseudo*Cfb) — with 500G and 200fF = 1.6 Hz
Rbias_p vcm_node inn_p {rpseudo}
Rbias_n vcm_node inn_n {rpseudo}
Vcm vcm_node 0 {vcm_val}

* ============================================================
* Feedback Capacitors (set closed-loop gain = Cin/Cfb)
* ============================================================
* Single-ended: feedback from output to inverting input
Cfb d2 inn_p {cfb_val}

* ============================================================
* Output and Load
* ============================================================
* Output is single-ended at d2
* Load cap (next stage input)
CL d2 0 1p

.end
