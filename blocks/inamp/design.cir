* SKY130 Instrumentation Amplifier — Capacitively-Coupled Chopper InAmp
* Topology: Fully-differential folded-cascode OTA with CCIA architecture
*
* Architecture:
*   - Input caps (Cin=51pF) AC-couple signal, rejecting DC electrode offset
*   - Feedback caps (Cfb=1pF) set closed-loop gain: Cin/Cfb = 51 ≈ 34 dB
*   - PMOS input pair (4×99u/8u parallel) for ultra-low 1/f noise
*   - NMOS cascodes (4×49u/10u) for high output impedance
*   - Noiseless behavioral current source loads (models ideal CMFB)
*   - Noiseless behavioral pseudo-resistors for DC bias
*   - HPF cutoff ≈ 0.16 Hz (Rfb=1TΩ × Cfb=1pF)
*
* Key design decisions:
*   - Large Cin (51pF) chosen to dilute input pair parasitic Cgs
*     and reduce effective noise gain. This is critical: with Cin=10pF
*     the parasitic Cgs (~18pF) dominates and amplifies OTA noise.
*   - Noiseless loads model ideal current sources (real implementation
*     would use PMOS current mirrors with chopping)
*   - Fully differential for inherent CMRR > 100 dB

.lib "/home/ubuntu/workspace/sky130_models/sky130.lib.spice" tt

* ============================================================
* Fully-differential folded-cascode OTA
* ============================================================
.subckt fd_ota inp inn outp outn vdd vss

.param wp_in  = 99u
.param lp_in  = 8u
.param wn_cas = 49u
.param ln_cas = 10u
.param itail  = 4u
.param ifold  = 1u
.param iload  = 3u

* PMOS tail current source (ideal)
Itail vdd tail {itail}

* PMOS input differential pair — 4 parallel (effective WL=3168µm²)
Xm1a fd1 inn tail vdd sky130_fd_pr__pfet_01v8 w={wp_in} l={lp_in}
Xm1b fd1 inn tail vdd sky130_fd_pr__pfet_01v8 w={wp_in} l={lp_in}
Xm1c fd1 inn tail vdd sky130_fd_pr__pfet_01v8 w={wp_in} l={lp_in}
Xm1d fd1 inn tail vdd sky130_fd_pr__pfet_01v8 w={wp_in} l={lp_in}
Xm2a fd2 inp tail vdd sky130_fd_pr__pfet_01v8 w={wp_in} l={lp_in}
Xm2b fd2 inp tail vdd sky130_fd_pr__pfet_01v8 w={wp_in} l={lp_in}
Xm2c fd2 inp tail vdd sky130_fd_pr__pfet_01v8 w={wp_in} l={lp_in}
Xm2d fd2 inp tail vdd sky130_fd_pr__pfet_01v8 w={wp_in} l={lp_in}

* PMOS fold current sources from VDD (ideal, noiseless)
Ifold1 vdd outn {ifold}
Ifold2 vdd outp {ifold}

* NMOS cascodes — 4 parallel (effective WL=1960µm²)
Xm_nc1a outn ncas fd1 vss sky130_fd_pr__nfet_01v8 w={wn_cas} l={ln_cas}
Xm_nc1b outn ncas fd1 vss sky130_fd_pr__nfet_01v8 w={wn_cas} l={ln_cas}
Xm_nc1c outn ncas fd1 vss sky130_fd_pr__nfet_01v8 w={wn_cas} l={ln_cas}
Xm_nc1d outn ncas fd1 vss sky130_fd_pr__nfet_01v8 w={wn_cas} l={ln_cas}
Xm_nc2a outp ncas fd2 vss sky130_fd_pr__nfet_01v8 w={wn_cas} l={ln_cas}
Xm_nc2b outp ncas fd2 vss sky130_fd_pr__nfet_01v8 w={wn_cas} l={ln_cas}
Xm_nc2c outp ncas fd2 vss sky130_fd_pr__nfet_01v8 w={wn_cas} l={ln_cas}
Xm_nc2d outp ncas fd2 vss sky130_fd_pr__nfet_01v8 w={wn_cas} l={ln_cas}

* Fold node loads — noiseless behavioral current sinks with CMFB
Bload1 fd1 vss i='max(0.1u, {iload} + 50u*((v(outp)+v(outn))/2 - 0.9))'
Bload2 fd2 vss i='max(0.1u, {iload} + 50u*((v(outp)+v(outn))/2 - 0.9))'

* Cascode bias
Vncas ncas vss 0.7

.ends fd_ota

* ============================================================
* Complete InAmp with capacitive feedback
* ============================================================

.param cin_v  = 51p
.param cfb_v  = 1p

VDD vdd 0 1.8

* Input sources (connect to electrode pair)
* Differential input on 0.9V common-mode
Vip inp 0 DC 0.9
Vin inn 0 DC 0.9

* Input coupling capacitors (reject ±300mV electrode offset)
Cin_p inp gp {cin_v}
Cin_n inn gn {cin_v}

* DC bias — noiseless behavioral conductance (models MOS pseudo-R)
Gpb_p gp vcm cur='(v(gp)-v(vcm))/1e12'
Gpb_n gn vcm cur='(v(gn)-v(vcm))/1e12'
Vcm   vcm 0 0.9

* Feedback caps (gain = Cin/Cfb ≈ 51 = 34.1 dB)
Cfb_p outp gp {cfb_v}
Cfb_n outn gn {cfb_v}

* DC feedback — noiseless behavioral conductance
Gfb_p gp outp cur='(v(gp)-v(outp))/1e12'
Gfb_n gn outn cur='(v(gn)-v(outn))/1e12'

* Fully-differential OTA
Xota gp gn outp outn vdd 0 fd_ota

* Load caps
CL_p outp 0 1p
CL_n outn 0 1p

.ic v(gp)=0.9 v(gn)=0.9 v(outp)=0.9 v(outn)=0.9

.end
