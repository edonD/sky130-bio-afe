* Capacitively-Coupled Instrumentation Amplifier (CCIA)
* SKY130 Process, 1.8V supply
* Topology: Fully-differential folded-cascode OTA with system-level chopping
* Gain = Cin/Cfb = 62pF/1pF = 62 V/V = 35.8 dB

.lib "sky130_models/sky130.lib.spice" tt

* ── Supply ──
Vdd vdd 0 1.8
Vss vss 0 0
Vcm vcm 0 0.9

* ── Bias Generation (1 uA reference) ──
Ibias_n vdd nbias 1u
XMnb nbias nbias vss vss sky130_fd_pr__nfet_01v8 w=2u l=8u m=1
XMpb1 pbias pbias vdd vdd sky130_fd_pr__pfet_01v8 w=2u l=8u m=1
Ibias_p pbias vss 1u

* ── Fully-Differential Folded-Cascode OTA ──
.subckt ota inp inn outp outn vcm vdd vss nbias pbias

* PMOS tail current source: 5 uA (5x mirror from 1uA ref)
XMtail tailn pbias vdd vdd sky130_fd_pr__pfet_01v8 w=10u l=8u m=1

* PMOS LVT input differential pair (large W for low 1/f noise)
* 8 parallel devices of 99u/8u = 792um total W per side
XM1 d1n inp tailn vdd sky130_fd_pr__pfet_01v8_lvt w=99u l=8u m=8
XM2 d2n inn tailn vdd sky130_fd_pr__pfet_01v8_lvt w=99u l=8u m=8

* NMOS folding current sources: ~2.7 uA each
XMf1 d1n nbias vss vss sky130_fd_pr__nfet_01v8 w=10.8u l=16u m=1
XMf2 d2n nbias vss vss sky130_fd_pr__nfet_01v8 w=10.8u l=16u m=1

* NMOS cascodes
XMc1 outn ncasc d1n vss sky130_fd_pr__nfet_01v8 w=49u l=2u m=2
XMc2 outp ncasc d2n vss sky130_fd_pr__nfet_01v8 w=49u l=2u m=2

* NMOS cascode bias
Vncasc ncasc vss 1.0

* PMOS loads (CMFB-controlled) — large L for high rds and low noise
XMl1 outn cmfb vdd vdd sky130_fd_pr__pfet_01v8 w=99u l=99u m=1
XMl2 outp cmfb vdd vdd sky130_fd_pr__pfet_01v8 w=99u l=99u m=1

* CMFB: when output CM rises above vcm, raise cmfb to turn off PMOS loads
Ecmfb cmfb 0 vol='0.9 + 100*((v(outp)+v(outn))/2 - v(vcm))'
.ends ota

* ── Instantiate OTA ──
Xota vgp vgn voutp_ota voutn_ota vcm vdd vss nbias pbias ota

* ── Input capacitors (Cin = 62 pF) ──
Cinp inp_chop_p vgp 62p
Cinn inp_chop_n vgn 62p

* ── Feedback capacitors (Cfb = 1 pF) ──
Cfbp voutp_ota vgn 1p
Cfbn voutn_ota vgp 1p

* ── DC bias for OTA inputs ──
Rbp vgp vcm 100G
Rbn vgn vcm 100G

* ── Chopper Switches (System-Level Chopping at 10 kHz) ──
.model SW1 SW vt=0.5 vh=0.01 ron=100 roff=1G
Vclk clk 0 pulse(0 1 0 1n 1n 50u 100u)
Eclkb clk_b 0 vol='1-v(clk)'

* Input chopper (modulator)
S1a inp inp_chop_p clk 0 SW1
S1b inn inp_chop_n clk 0 SW1
S1c inp inp_chop_n clk_b 0 SW1
S1d inn inp_chop_p clk_b 0 SW1

* Output chopper (demodulator)
S2a voutp_ota vout_dem_p clk 0 SW1
S2b voutn_ota vout_dem_n clk 0 SW1
S2c voutp_ota vout_dem_n clk_b 0 SW1
S2d voutn_ota vout_dem_p clk_b 0 SW1

* Output LPF (reconstruct after demod)
Rlpfp vout_dem_p voutp 10k
Clpfp voutp vcm 100p
Rlpfn vout_dem_n voutn 10k
Clpfn voutn vcm 100p

* ── Test stimulus (1 mV differential) ──
Vinp inp 0 dc 0.9005 ac 0.5
Vinn inn 0 dc 0.8995 ac -0.5

.control
op
print v(voutp) v(voutn) v(voutp)-v(voutn)
ac dec 50 0.1 1Meg
wrdata ac_response.dat v(voutp)-v(voutn)
.endc
.end
