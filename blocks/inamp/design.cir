* SKY130 Instrumentation Amplifier — Capacitively-Coupled OTA
* Baseline: PMOS-input folded-cascode OTA with capacitive feedback
* Gain = Cin/Cfb ~ 50 V/V (34 dB)
*
* Topology: Capacitively-coupled instrumentation amplifier (CCIA)
* - Input capacitors (Cin) AC-couple the signal, rejecting DC electrode offset
* - Feedback capacitors (Cfb) set the closed-loop gain
* - Large pseudo-resistors set DC bias and low-frequency cutoff
* - PMOS input pair for low 1/f noise
* - Folded-cascode output for high gain and output swing

.lib "/home/ubuntu/workspace/sky130_models/sky130.lib.spice" tt

.param vdd_val = 1.8
.param vcm_val = 0.9
.param ibias_val = 2u

* ============================================================
* Parameters (will be overridden by evaluate.py)
* ============================================================
.param wp_in = 50u       ; Input PMOS pair W
.param lp_in = 2u        ; Input PMOS pair L
.param wn_load = 5u      ; NMOS load W
.param ln_load = 2u      ; NMOS load L
.param wp_tail = 10u     ; PMOS tail current source W
.param lp_tail = 2u      ; PMOS tail current source L
.param wp_cas = 5u       ; PMOS cascode W
.param lp_cas = 1u       ; PMOS cascode L
.param wn_cas = 5u       ; NMOS cascode W
.param ln_cas = 1u       ; NMOS cascode L
.param cin_val = 10p     ; Input coupling capacitor
.param cfb_val = 200f    ; Feedback capacitor (gain = cin/cfb = 50)
.param rpseudo = 100G    ; Pseudo-resistor for DC bias

* ============================================================
* Supply
* ============================================================
VDD vdd 0 {vdd_val}
VSS vss 0 0

* ============================================================
* Bias generation - simple current mirror
* ============================================================
* Bias current reference (ideal for baseline)
Ibias vdd nbias {ibias_val}
Xbias_n nbias nbias vss vss sky130_fd_pr__nfet_01v8 w={wn_load} l={ln_load}

* ============================================================
* Input coupling capacitors
* ============================================================
Cin_p inp inn_p {cin_val}
Cin_n inn inn_n {cin_val}

* ============================================================
* DC bias for OTA inputs via pseudo-resistors
* ============================================================
Rbias_p vcm inn_p {rpseudo}
Rbias_n vcm inn_n {rpseudo}
Vcm_bias vcm 0 {vcm_val}

* ============================================================
* Feedback capacitors (gain = Cin/Cfb)
* ============================================================
Cfb_p outp inn_p {cfb_val}
Cfb_n outn inn_n {cfb_val}

* ============================================================
* Folded-Cascode OTA (fully differential)
* ============================================================

* --- PMOS tail current source ---
Xp_tail_bias ptail_bias ptail_bias vdd vdd sky130_fd_pr__pfet_01v8 w={wp_tail} l={lp_tail}
Ip_tail_ref vdd ptail_bias {ibias_val*2}
Xp_tail tail ptail_bias vdd vdd sky130_fd_pr__pfet_01v8 w={wp_tail} l={lp_tail}

* --- PMOS input differential pair ---
Xp_in1 pd1 inn_n tail vdd sky130_fd_pr__pfet_01v8 w={wp_in} l={lp_in}
Xp_in2 pd2 inn_p tail vdd sky130_fd_pr__pfet_01v8 w={wp_in} l={lp_in}

* --- NMOS load current sources (folded-cascode bias) ---
Xn_load1 nd1 nbias vss vss sky130_fd_pr__nfet_01v8 w={wn_load} l={ln_load}
Xn_load2 nd2 nbias vss vss sky130_fd_pr__nfet_01v8 w={wn_load} l={ln_load}

* --- NMOS cascodes ---
Xn_cas1 outn ncas_bias nd1 vss sky130_fd_pr__nfet_01v8 w={wn_cas} l={ln_cas}
Xn_cas2 outp ncas_bias nd2 vss sky130_fd_pr__nfet_01v8 w={wn_cas} l={ln_cas}

* --- PMOS cascodes ---
Xp_cas1 outn pcas_bias pd1 vdd sky130_fd_pr__pfet_01v8 w={wp_cas} l={lp_cas}
Xp_cas2 outp pcas_bias pd2 vdd sky130_fd_pr__pfet_01v8 w={wp_cas} l={lp_cas}

* --- Cascode bias generation ---
* NMOS cascode bias ~ 0.6V
Vncas ncas_bias 0 0.7
* PMOS cascode bias ~ VDD - 0.6V = 1.2V
Vpcas pcas_bias 0 1.0

* ============================================================
* Output common-mode feedback (CMFB) — simplified
* Uses ideal VCVS to sense output CM and correct tail
* ============================================================
* Sense output common-mode: vcm_out = (outp + outn)/2
Ecmfb vcm_sense 0 vol='(v(outp)+v(outn))/2'
* CMFB error amp: adjusts a current to correct output CM
Gcmfb outp outn vcm_sense vcm 10u

* ============================================================
* Load capacitors (simulating next stage input)
* ============================================================
CL_p outp 0 1p
CL_n outn 0 1p

.end
