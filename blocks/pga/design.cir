* PGA - Programmable Gain Amplifier
* SKY130 Process, 1.8V supply
* Inverting topology with two-stage Miller opamp (NMOS input)
* Gains: 1, 2, 4, 8, 16, 32, 64, 128

.lib "sky130_models/sky130.lib.spice" tt

.param gain_val = 1
.param rf_val = 10Meg
.param rin_val = {rf_val / gain_val}
.param vcm = 0.9

Vdd vdd 0 1.8
Vss vss 0 0
Vcm vcm_node 0 {vcm}

** Two-Stage Miller Compensated CMOS Opamp (NMOS input)
.subckt opamp inp inn out vdd vss

* Bias: 1uA ref through NMOS diode
Ibias vdd nbias 1u
XMn_diode nbias nbias vss vss sky130_fd_pr__nfet_01v8 w=2u l=4u m=1

* First stage: NMOS diff pair + PMOS active load
XM5 tail nbias vss vss sky130_fd_pr__nfet_01v8 w=2u l=4u m=2
XM1 d1 inp tail vss sky130_fd_pr__nfet_01v8 w=8u l=4u m=1
XM2 d2 inn tail vss sky130_fd_pr__nfet_01v8 w=8u l=4u m=1
XM3 d2 d2 vdd vdd sky130_fd_pr__pfet_01v8 w=4u l=8u m=1
XM4 d1 d2 vdd vdd sky130_fd_pr__pfet_01v8 w=4u l=8u m=1

* Second stage: PMOS CS + NMOS load
XM6 out d1 vdd vdd sky130_fd_pr__pfet_01v8 w=8u l=8u m=1
XM7 out nbias vss vss sky130_fd_pr__nfet_01v8 w=2u l=8u m=2

* Miller compensation (~1.6 pF) + nulling resistor
XCc d1 cc_mid sky130_fd_pr__cap_mim_m3_1 w=28u l=28u m=1
Rz cc_mid out 1.5k

.ends opamp

* PGA: inverting configuration
X1 vcm_node vminus vout vdd vss opamp
Rf vminus vout {rf_val}
Rin vin vminus {rin_val}
Vin vin 0 dc {vcm} ac 10m

.end
